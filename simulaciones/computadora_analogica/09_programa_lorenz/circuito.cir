Lorenz (Fig. 18): variables escaladas X=x/10, Y=y/10, Z=z/10

* LF412 (macro-modelo): Aol 2e5, GBW ~3 MHz, salida limitada a +/-13.5 V
.subckt LF412 inp inn out
Rin inp inn 1e12
E1 n1 0 inp inn 2e5
R1 n1 n2 1k
C1 n2 0 10.6u
B1 out 0 V = 13.5*tanh(V(n2)/13.5)
.ends
* AD633: W = (X1-X2)(Y1-Y2)/10 + Z, salida limitada a +/-11 V
.subckt AD633 x1 x2 y1 y2 z w
B1 w 0 V = 11*tanh(((V(x1)-V(x2))*(V(y1)-V(y2))/10 + V(z))/11)
.ends
* Rele G5V-2 como conmutadores controlados por OP (umbral 6 V)
.model RELNO SW(Vt=6 Vh=0.5 Ron=0.05 Roff=1e10)
.model RELNC SW(Vt=-6 Vh=0.5 Ron=0.05 Roff=1e10)
* Transistores (modelos SPICE publicados por los fabricantes)
.model 2N3904 NPN(Is=6.734f Xti=3 Eg=1.11 Vaf=74.03 Bf=416.4 Ne=1.259 Ise=6.734f Ikf=66.78m Xtb=1.5
+ Br=.7371 Nc=2 Isc=0 Ikr=0 Rc=1 Cjc=3.638p Mjc=.3085 Vjc=.75 Fc=.5 Cje=4.493p Mje=.2593 Vje=.75
+ Tr=239.5n Tf=301.2p Itf=.4 Vtf=4 Xtf=2 Rb=10)
.model 2N3906 PNP(Is=1.41f Xti=3 Eg=1.11 Vaf=18.7 Bf=180.7 Ne=1.5 Ise=0 Ikf=80m Xtb=1.5 Br=4.977
+ Nc=2 Isc=0 Ikr=0 Rc=2.5 Cjc=9.728p Mjc=.5776 Vjc=.75 Fc=.5 Cje=8.063p Mje=.3677 Vje=.75 Tr=33.42n
+ Tf=179.3p Itf=.4 Vtf=4 Xtf=6 Rb=10)
.model BD139 NPN(Is=2.3985E-13 Bf=244.9 Vaf=100 Ikf=1.0 Ise=1.0E-14 Ne=1.5 Br=7.0 Rb=0.5 Rc=0.15 Re=0.1
+ Cje=1.4E-10 Cjc=4.0E-11 Tf=1.0E-9 Tr=2.0E-7)
.model BD140 PNP(Is=2.3985E-13 Bf=150 Vaf=100 Ikf=1.0 Ise=1.0E-14 Ne=1.5 Br=7.0 Rb=0.5 Rc=0.15 Re=0.1
+ Cje=1.4E-10 Cjc=4.0E-11 Tf=1.0E-9 Tr=2.0E-7)
.model LEDR D(Is=1e-19 N=1.7 Rs=5 Cjo=30p)
.model LEDG D(Is=1e-21 N=1.8 Rs=5 Cjo=30p)
.model 1N4148 D(Is=2.52n Rs=.568 N=1.752 Cjo=4p M=.4 Tt=20n)
.model 1N4007 D(Is=7.02767n Rs=0.0341512 N=1.80803 Cjo=1e-11 M=0.3 Tt=1e-6)

Vop op 0 PWL(0 0 0.1 0 0.101 12 40 12)
Vicx icx 0 -0.1
Vicy icy 0 -0.1
Vicz icz 0 -0.1
* INT1 -> XN = -X :  entradas Y (100k) y XN (100k)        dX/dt = 10(Y - X)
* --- integrador xn ---
Rxni0 y xn_sum 100k
Rxni1 xn xn_sum 100k
Rxn6 icx xn_icn 10k
Rxn7 xn_icn xn 10k
Sxna xn_icn xn_inv 0 op RELNC
Sxnb xn_icn 0 op 0 RELNO
Sxnc xn_sum 0 0 op RELNC
Sxnd xn_sum xn_inv op 0 RELNO
Cxn xn_inv xn 1u
Xxn 0 xn_inv xn LF412
* INT2 -> Y : entradas XN (35.7k), Y (1M), W1 = XZ/10 (10k)  dY/dt = 28X - Y - 10XZ
* --- integrador y ---
Ryi0 xn y_sum 35.7k
Ryi1 y y_sum 1Meg
Ryi2 w1 y_sum 10k
Ry6 icy y_icn 10k
Ry7 y_icn y 10k
Sya y_icn y_inv 0 op RELNC
Syb y_icn 0 op 0 RELNO
Syc y_sum 0 0 op RELNC
Syd y_sum y_inv op 0 RELNO
Cy y_inv y 1u
Xy 0 y_inv y LF412
* INT3 -> ZN = -Z : entradas ZN (374k), W2 = XY/10 (10k)   dZ/dt = -8/3 Z + 10XY
* --- integrador zn ---
Rzni0 zn zn_sum 374k
Rzni1 w2 zn_sum 10k
Rzn6 icz zn_icn 10k
Rzn7 zn_icn zn 10k
Szna zn_icn zn_inv 0 op RELNC
Sznb zn_icn 0 op 0 RELNO
Sznc zn_sum 0 0 op RELNC
Sznd zn_sum zn_inv op 0 RELNO
Czn zn_inv zn 1u
Xzn 0 zn_inv zn LF412
* inversor (M4): Z = -ZN
* --- sumador z ---
Rzi0 zn z_inv 10k
Rzf z_inv z 10k
Xz 0 z_inv z LF412
* multiplicadores (M7): W1 = (0 - XN) * Z / 10 = XZ/10 ; W2 = (0 - XN) * Y / 10 = XY/10
XM1 0 xn z 0 0 w1 AD633
XM2 0 xn y 0 0 w2 AD633
.tran 2m 30 0 2m uic
.end
