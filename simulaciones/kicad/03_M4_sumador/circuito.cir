.title KiCad schematic
.include "C:/Users/opcio/1-Proyectos-Business/computadora-analogica/simulaciones/kicad/modelos.lib"
.tran 2m 2
XU1 Net-_SW1-B_ Net-_U1A--_ GND -15V GND Net-_U1B--_ Net-_U1B--_ +15V LF412
XRV1 Net-_U1A--_ unconnected-_RV1-Pad2_ Net-_SW1-C_ POT r=100k pos=0.5
R4 Net-_R4-Pad1_ Net-_U1A--_ 100k
R5 unconnected-_R5-Pad1_ Net-_U1A--_ 100k
R1 unconnected-_R1-Pad1_ Net-_U1A--_ 1k
R3 unconnected-_R3-Pad1_ Net-_U1A--_ 10k
R2 Net-_R2-Pad1_ Net-_U1A--_ 10k
XSW1 Net-_SW1-A_ Net-_SW1-B_ Net-_SW1-C_ SPDT_A
C2 GND -15V 100n
V1 +15V GND DC 15
V2 GND -15V DC 15
C1 +15V GND 100n
R6 Net-_U1A--_ Net-_SW1-A_ 10k
V4 Net-_R4-Pad1_ GND DC 10
V3 Net-_R2-Pad1_ GND DC 0 SIN( 0 2 1 )
.end
